// Design: AND_Gate/inverter_test
simulator lang=spectre
global 0
include "/home/sudipto-uiu/cadence/gpdk090_v4.6/libs.oa22/gpdk090/../../models/spectre/gpdk090.scs" section=NN

// AND_Gate/inverter/schematic
subckt inverter VDD VSS A B Output
    NM2 (Output net06 VSS VSS) gpdk090_nmos1v w=(240n) l=100n m=(1)*(1) simM=(1)*(1)
    NM1 (net15 B VSS VSS) gpdk090_nmos1v w=(240n) l=100n m=(1)*(1) simM=(1)*(1)
    NM0 (net06 A net15 VSS) gpdk090_nmos1v w=(240n) l=100n m=(1)*(1) simM=(1)*(1)
    PM2 (Output net06 VDD VDD) gpdk090_pmos1v w=(720n) l=100n m=(1)*(1) simM=(1)*(1)
    PM1 (VDD B net06 VDD) gpdk090_pmos1v w=(720n) l=100n m=(1)*(1) simM=(1)*(1)
    PM0 (net06 A VDD VDD) gpdk090_pmos1v w=(720n) l=100n m=(1)*(1) simM=(1)*(1)
ends inverter

// AND_Gate/inverter_test/schematic
I0 (net3 0 A B Output) inverter
V0 (net3 0) vsource dc=1.8 type=dc
V2 (B 0) vsource type=pulse val0=0 val1=1.8 period=40n rise=50p fall=50p width=20n
V1 (A 0) vsource type=pulse val0=0 val1=1.8 period=20n rise=50p fall=50p width=10n
simulatorOptions options temp=27
tran tran stop=200n errpreset=moderate
dcOp dc
dc dc param=dc start=0 stop=1.8
save A B Output
