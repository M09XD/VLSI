simulator( 'spectre )
design(	 "/home/sudipto-uiu/AND_Gate/inverter_test/spectre/schematic/netlist/netlist")
resultsDir( "/home/sudipto-uiu/AND_Gate/inverter_test/spectre/schematic" )
modelFile(
    '("/home/sudipto-uiu/cadence/gpdk090_v4.6/libs.oa22/gpdk090/../../models/spectre/gpdk090.scs" "NN")
)
analysis('tran ?stop "200n"  ?errpreset "moderate"  )
analysis('dc ?saveOppoint t  ?dev "/V1 V2"  ?param "dc"
		?start "0"  ?stop "1.8"  )
envOption(
	'analysisOrder  list("tran" "dc")
)
save( 'v "/A" "/B" "/Output" )
temp( 27 )
run()
selectResult( 'dc )
plot(getData("/A") getData("/B") getData("/Output") )
selectResult( 'tran )
plot(getData("/A") getData("/B") getData("/Output") )
Inverter_Delay = delay(VT("/vin") 0.6 1 "rising" VT("/vout") 0.6 1 "falling")
plot( Inverter_Delay ?expr '( "Inverter_Delay" ) )
