simulator( 'spectre )
design(	 "/home/sudipto-uiu/NAND_Gate/inverter_test/spectre/schematic/netlist/netlist")
resultsDir( "/home/sudipto-uiu/NAND_Gate/inverter_test/spectre/schematic" )
modelFile(
    '("/home/sudipto-uiu/cadence/gpdk090_v4.6/libs.oa22/gpdk090/../../models/spectre/gpdk090.scs" "NN")
)
analysis('dc ?saveOppoint t  ?dev "/V1 V2"  ?param "dc"
		?start "0"  ?stop "1.8"  )
analysis('tran ?stop "200n"  ?errpreset "moderate"  )
envOption(
	'analysisOrder  list("tran" "dc")
)
save( 'v "/A" "/B" "/Output" )
temp( 27 )
run()
selectResult( 'tran )
plot(getData("/A") getData("/B") getData("/Output") )
selectResult( 'dc )
plot(getData("/A") getData("/B") getData("/Output") )
modelFile(
    '("/home/sudipto-uiu/cadence/gpdk090_v4.6/libs.oa22/gpdk090/../../models/spectre/gpdk090.scs" "NN")
)
run()
selectResult( 'tran )
plot(getData("/A") getData("/B") getData("/Output") )
selectResult( 'dc )
plot(getData("/A") getData("/B") getData("/Output") )
