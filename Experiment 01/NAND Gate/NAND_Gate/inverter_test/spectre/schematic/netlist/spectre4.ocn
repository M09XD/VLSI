simulator( 'spectre )
design(	 "/home/sudipto-uiu/NAND_Gate/inverter_test/spectre/schematic/netlist/netlist")
resultsDir( "/home/sudipto-uiu/NAND_Gate/inverter_test/spectre/schematic" )
modelFile(
    '("/home/sudipto-uiu/cadence/gpdk090_v4.6/libs.oa22/gpdk090/../../models/spectre/gpdk090.scs" "NN")
)
analysis('tran ?stop "200n"  ?errpreset "moderate"  )
envOption(
	'analysisOrder  list("tran")
)
save( 'v "/A" "/B" "/Output" )
temp( 27 )
run()
selectResult( 'tran )
plot(getData("/A") getData("/B") getData("/Output") )
