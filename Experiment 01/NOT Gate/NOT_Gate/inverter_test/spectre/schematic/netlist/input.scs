// Design: NOT_Gate/inverter_test
simulator lang=spectre
global 0
include "/home/sudipto-uiu/cadence/gpdk090_v4.6/libs.oa22/gpdk090/../../models/spectre/gpdk090.scs" section=NN

// NOT_Gate/inverter/schematic
subckt inverter In Out VDD VSS
    NM0 (Out In VSS VSS) gpdk090_nmos1v w=(240n) l=100n m=(1)*(1) simM=(1)*(1)
    PM0 (Out In VDD VDD) gpdk090_pmos1v w=(720n) l=100n m=(1)*(1) simM=(1)*(1)
ends inverter

// NOT_Gate/inverter_test/schematic
I0 (net5 Out net4 net6) inverter
V0 (0 net4) vsource dc=1.8 type=dc
V1 (0 net5) vsource type=pulse val0=0 val1=1.8 period=20n width=10n
simulatorOptions options temp=27
tran tran stop=200n errpreset=moderate
dcOp dc
dc dc dev=V1 param=dc start=0 stop=1.0
save V1:p V1:p I0:1 I0:2 I0:3 I0:4 V0:p V0:p
