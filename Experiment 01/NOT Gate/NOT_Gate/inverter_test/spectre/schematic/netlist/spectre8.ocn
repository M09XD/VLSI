simulator( 'spectre )
design(	 "/home/sudipto-uiu/NOT_Gate/inverter_test/spectre/schematic/netlist/netlist")
resultsDir( "/home/sudipto-uiu/NOT_Gate/inverter_test/spectre/schematic" )
modelFile(
    '("/home/sudipto-uiu/cadence/gpdk090_v4.6/libs.oa22/gpdk090/../../models/spectre/gpdk090.scs" "NN")
)
analysis('dc ?saveOppoint t  ?dev "/V1"  ?param "dc"
		?start "0"  ?stop "1.0"  )
analysis('tran ?stop "200n"  ?errpreset "moderate"  )
envOption(
	'analysisOrder  list("tran" "dc")
)
save( 'i "/I0/In" "/I0/Out" )
temp( 27 )
run()
selectResult( 'tran )
plot(getData("/I0/In") getData("/I0/Out") )
selectResult( 'dc )
plot(getData("/I0/In") getData("/I0/Out") )
modelFile(
    '("/home/sudipto-uiu/cadence/gpdk090_v4.6/libs.oa22/gpdk090/../../models/spectre/gpdk090.scs" "NN")
)
save( 'i "/V1/MINUS" "/V1/PLUS" "/I0/VDD" "/I0/VSS" )
run()
selectResult( 'tran )
plot(getData("/V1/MINUS") getData("/V1/PLUS") getData("/I0/In") getData("/I0/Out") getData("/I0/VDD") getData("/I0/VSS") )
selectResult( 'dc )
plot(getData("/V1/MINUS") getData("/V1/PLUS") getData("/I0/In") getData("/I0/Out") getData("/I0/VDD") getData("/I0/VSS") )
modelFile(
    '("/home/sudipto-uiu/cadence/gpdk090_v4.6/libs.oa22/gpdk090/../../models/spectre/gpdk090.scs" "NN")
)
run()
selectResult( 'tran )
plot(getData("/V1/MINUS") getData("/V1/PLUS") getData("/I0/In") getData("/I0/Out") getData("/I0/VDD") getData("/I0/VSS") )
selectResult( 'dc )
plot(getData("/V1/MINUS") getData("/V1/PLUS") getData("/I0/In") getData("/I0/Out") getData("/I0/VDD") getData("/I0/VSS") )
